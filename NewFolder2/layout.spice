* SPICE INPUT		Sun May 10 11:23:21 2026	not
* EV_NETLIST Version AMD.64 Release B-2008.09.SP5.26005 2012/07/14
*
*The following line needed for Star-CR:
*CRU_OPT (KEEP_ELEMENTS "^[CR]D")
*
*The following line needed for CDL:
*.BIPOLAR

* Top of hierarchy  cell=not
.subckt not vdd! gnd! out in
M_MM0 gnd! in out ln_N_9 N  l=0.200u w=0.360u
M_MM1 vdd! in out ln_N_12 P  l=0.200u w=1.440u
.ends not
